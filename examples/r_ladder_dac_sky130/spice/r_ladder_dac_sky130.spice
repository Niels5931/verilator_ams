* 4-bit R-2R ladder DAC using Sky130 res_xhigh_po resistors
.lib {PDK_ROOT}/open_pdks/sky130A/libs.tech/combined/sky130.lib.spice tt

* Power supply
VVDD VDD 0 1.8

* Digital bit inputs driven by Verilator via GetVSRCData callback
Vb0 b0 0 EXTERNAL
Vb1 b1 0 EXTERNAL
Vb2 b2 0 EXTERNAL
Vb3 b3 0 EXTERNAL

* R-2R ladder built from Sky130 high-resistance poly resistors.
* res_xhigh_po is approximately 2 kOhm/square; w=0.5 gives
* ~10 kOhm for l=2.5 and ~20 kOhm for l=5.0.
XRb3 b3 vout 0 sky130_fd_pr__res_xhigh_po w=0.5 l=5.0
XR32 vout n2 0 sky130_fd_pr__res_xhigh_po w=0.5 l=2.5
XRb2 b2 n2 0 sky130_fd_pr__res_xhigh_po w=0.5 l=5.0
XR21 n2 n1 0 sky130_fd_pr__res_xhigh_po w=0.5 l=2.5
XRb1 b1 n1 0 sky130_fd_pr__res_xhigh_po w=0.5 l=5.0
XR10 n1 n0 0 sky130_fd_pr__res_xhigh_po w=0.5 l=2.5
XRb0 b0 n0 0 sky130_fd_pr__res_xhigh_po w=0.5 l=5.0

* Termination at the LSB end
XRterm n0 0 0 sky130_fd_pr__res_xhigh_po w=0.5 l=5.0

* Transient analysis (must cover all 16 clock periods)
.tran 10n 5u

.end
