* Ideal 4-bit SAR ADC co-simulation testbench
* Replace {VIN} with the desired DC input voltage before loading.

VVIN vin 0 {VIN}

* Digital DAC value driven by Verilator via GetVSRCData callback
Vdac_code dac_code 0 EXTERNAL

* Ideal 4-bit DAC: the external source is already scaled to (code/15)*1.8V
Bdac vdac 0 V=V(dac_code)

* Ideal comparator: cmp_out = 1.8V when vin >= vdac, else 0V
Bcmp cmp_out 0 V=( V(vin) >= V(vdac) ? 1.8 : 0.0 )

* Transient analysis (run long enough for several conversions)
.tran 10n 10u

.end
