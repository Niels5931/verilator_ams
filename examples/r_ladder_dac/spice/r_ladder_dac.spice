* 4-bit R-2R ladder DAC co-simulation testbench

* Power supply
VVDD VDD 0 1.8

* Digital bit inputs driven by Verilator via GetVSRCData callback
Vb0 b0 0 EXTERNAL
Vb1 b1 0 EXTERNAL
Vb2 b2 0 EXTERNAL
Vb3 b3 0 EXTERNAL

* R-2R ladder (R = 10k, 2R = 20k)
* Output (vout) is at the MSB side; the far end (n0) is terminated to ground.
Rb3 b3 vout 20k
R32 vout n2 10k
Rb2 b2 n2 20k
R21 n2 n1 10k
Rb1 b1 n1 20k
R10 n1 n0 10k
Rb0 b0 n0 20k

* Termination at the LSB end
Rterm n0 0 20k

* Transient analysis (must cover all 16 clock periods)
.tran 10n 5u

.end
